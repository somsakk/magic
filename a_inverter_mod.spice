* SPICE3 file created from a_inverter.ext - technology: scmos

.option scale=0.3u

M1000 Z A gnd Gnd nfet w=10 l=2
+  ad=50p pd=30u as=50p ps=30u
M1001 Z A vdd vdd pfet w=20 l=2
+  ad=100p pd=50u as=100p ps=50u
C0 vdd 0 5.3118f
**FLOATING

.include ami05.txt

Vpower vdd gnd 3.3
Vin A gnd pulse(0, 3.3, 100p, 50p, 50p, 450p, 1000p)

.tran 1p 1500p
.end
